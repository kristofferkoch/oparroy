* tb_decode — decode margins of the PHY segment RX path
* (DESIGN.md §2, docs/phy-analysis.md §2): WS2812-style
* duty-coded cells through switch + lumped segment + OPA comparator
* must decode on the correct side of the cell midpoint with >= 100 ns
* of high-time margin (the §2 budget is ±160 ns; the analog front end
* must eat less than that).
*
* Bench: 15-cell stream, bits 0,1,0,1,1,0,0,1,1,1,0,0,0,1,0 (runs of
* both; the last cell only supplies the closing edge for cell 13's
* period measurement). Cell period 1.25 us, T0H = 395 ns, T1H = 792
* ns. PWL 0/3.3 V source with 5 ns edges; the bypass input is driven
* through 50 ohm (upstream TX pin stand-in), the inserted path's own
* ch32v003_tx_pin model carries its 50 ohm internally.
*
* Slice levels: the capture input is TIM2_CH1 on the internal OPO
* route, whose thresholds are undocumented (quirks.md §OPA) — the only
* datasheet bounds are the pad Schmitt spec (DS0 §3.3.9 T3-16): rising
* trip VT+ <= VIH_min = 1.68 V, falling trip VT- >= VIL_max = 0.76 V,
* hysteresis >= 150 mV. The bench scans rxout with three band
* placements: center 1.30/1.15 V (the modeling choice, band centered
* near the ~0.37xVDD typical), and the two legal extremes — high band
* 1.68/1.53 V, low band 0.91/0.76 V — plus the pessimistic VDD/2 slice
* (1.65/1.65 V). The 100 ns contract is asserted at the center band;
* the extreme placements are measured and echoed: they quantify how
* much band misplacement the front end absorbs (sensitivity set by the
* comparator's 7.7 V/us slew — the output ramp does not settle between
* edges), and the real chip's placement is a bring-up measurement (the
* §6 opo/PD4 tap exists for exactly this).
*
* Sweeps (alterparam + reset, house style), 24 runs x 4 slices:
*   cseg in {47p, 220p, 470p, 1n}  — connector + cable + next-node C
*   voff in {-13m, 0, +13m}        — OPA offset worst cases (DS0
*                                    §3.3.15 T3-26)
*   path:  psel=0 bypass (up driven), psel=3.3 inserted (txin driven)
*   slice: the three Schmitt placements above + VDD/2
*
* Assertions, per cell (14 cells x 24 runs), at the center band:
*   a1 '0' cell: high-time < period/2 - 100 ns
*   a2 '1' cell: high-time > period/2 + 100 ns
*   a3 every cell, every slice: period within 0.9..1.6 us (firmware
*      legal-cell window, DESIGN.md §2)
* a1/a2 are checked with sign (wrong-side decode fails even when far
* from the midpoint); corner-slice margins are echoed, not asserted.
*
* Results (ngspice 45): all 24 runs pass the 100 ns contract at the
* center band — worst margin +78.2 ns net of the contract (cseg=1n,
* voff=-13m, bypass); flat vs cseg (+-3 ns) and vs voff (< 2 ns). At
* the legal band extremes: high band worst +58.1 ns — still in
* contract; low band worst -29.0 ns — OUT of contract in all 24 runs
* (cells still decode on the correct side of the midpoint: worst
* distance 71 ns vs the contracted 100). Band-center sensitivity is
* ~27 ns per 100 mV (2/slew, as expected — the comparator's 7.7 V/us
* ramp does not settle between edges). VDD/2 slice: worst +45.7 ns.
* Periods 1249..1251 ns at every slice — a healthy segment never
* trips the 0.9..1.6 us illegal-cell detector. Line 10-90% edges
* scale with cseg as ~2.2*57ohm*C: 7.2 / 28 / 59 / 125 ns for
* 47p..1n. The binding effect is the slew, not cseg: delays are
* pattern-dependent (falling-edge delay 184 ns after a '0' cell vs
* 229 ns after a '1' cell at 220p inserted).
*
.include phy-segment.cir
.param cseg=220p voff=0 psel=0

Vdd vdd 0 3.3

* 15 cells at 1.25 us, first rising edge at 100 ns, 5 ns edges.
Vst stim 0 PWL(
+ 0n 0
+ 95n 0 100n 3.3 495n 3.3 500n 0
+ 1.345u 0 1.35u 3.3 2.142u 3.3 2.147u 0
+ 2.595u 0 2.6u 3.3 2.995u 3.3 3u 0
+ 3.845u 0 3.85u 3.3 4.642u 3.3 4.647u 0
+ 5.095u 0 5.1u 3.3 5.892u 3.3 5.897u 0
+ 6.345u 0 6.35u 3.3 6.745u 3.3 6.75u 0
+ 7.595u 0 7.6u 3.3 7.995u 3.3 8u 0
+ 8.845u 0 8.85u 3.3 9.642u 3.3 9.647u 0
+ 10.095u 0 10.1u 3.3 10.892u 3.3 10.897u 0
+ 11.345u 0 11.35u 3.3 12.142u 3.3 12.147u 0
+ 12.595u 0 12.6u 3.3 12.995u 3.3 13u 0
+ 13.845u 0 13.85u 3.3 14.245u 3.3 14.25u 0
+ 15.095u 0 15.1u 3.3 15.495u 3.3 15.5u 0
+ 16.345u 0 16.35u 3.3 17.142u 3.3 17.147u 0
+ 17.595u 0 17.6u 3.3 17.995u 3.3 18u 0
+ 20u 0)

Rup stim up 50
Rtx stim txin 1m
Bsel sel 0 V={psel}

Xphy up txin sel line rxout vdd 0 phy_segment
+ params: cseg={cseg} voff={voff}

.control
* cell bit pattern, cells 0..13 (cell 14 closes cell 13's period)
compose bits values 0 1 0 1 1 0 0 1 1 1 0 0 0 1

* Schmitt band placements 0..2 (center / high / low), slice 3 = VDD/2
compose vtrv values 1.30 1.68 0.91
compose vtfv values 1.15 1.53 0.76

* per-slice global worst signed margin (net of the 100 ns contract),
* plus the global period extremes (any slice)
let gm = vector(4)
let i = 0
while i < 4
  let gm[i] = 1e9
  let i = i + 1
end
let gpmin = 1
let gpmax = 0

foreach cs 47p 220p 470p 1n
  foreach vo -13m 0 13m
    foreach ps 0 3.3
      alterparam cseg = $cs
      alterparam voff = $vo
      alterparam psel = $ps
      reset
      tran 5n 20u uic

      * line edge rates, 10-90% (second edge: past any startup)
      meas tran trise trig v(line) val=0.33 rise=2 targ v(line) val=2.97 rise=2
      meas tran tfall trig v(line) val=2.97 fall=2 targ v(line) val=0.33 fall=2

      let v = v(rxout)
      let tt = time
      let n = length(v)

      * per-slice run results, collected for the echo line
      let rms = vector(4)
      let badper = 0

      let sl = 0
      while sl < 4
        if sl = 3
          let vtr = 1.65
          let vtf = 1.65
        else
          let vtr = vtrv[sl]
          let vtf = vtfv[sl]
        end

        * scan rxout: open each cell at the rise through vtr, close it
        * at the fall through vtf (linear interpolation between points)
        let rises = vector(15)
        let ths = vector(14)
        let nr = 0
        let state = 0
        let topen = 0
        let i = 1
        while i < n
          if (state = 0) & (v[i-1] < vtr) & (v[i] >= vtr)
            let state = 1
            let topen = tt[i-1] + (vtr - v[i-1])*(tt[i]-tt[i-1])/(v[i]-v[i-1])
            if nr < 15
              let rises[nr] = topen
            end
            let nr = nr + 1
          end
          if (state = 1) & (v[i-1] > vtf) & (v[i] <= vtf)
            let state = 0
            let tc = tt[i-1] + (vtf - v[i-1])*(tt[i]-tt[i-1])/(v[i]-v[i-1])
            if (nr > 0) & (nr <= 14)
              let ths[nr-1] = tc - topen
            end
          end
          let i = i + 1
        end
        if nr ne 15
          echo "FAIL cseg=$cs voff=$vo psel=$ps slice=$&sl: $&nr rises, bench broken"
          quit 1
        end

        * worst signed margin vs the 100 ns contract + period window
        let rmin = 1e9
        let pmin = 1
        let pmax = 0
        let k = 0
        while k < 14
          let per = rises[k+1] - rises[k]
          let th = ths[k]
          if bits[k] = 0
            let mrg = per/2 - th - 100n
          else
            let mrg = th - per/2 - 100n
          end
          if mrg < rmin
            let rmin = mrg
          end
          if per < pmin
            let pmin = per
          end
          if per > pmax
            let pmax = per
          end
          let k = k + 1
        end
        if (pmin < 0.9e-6) | (pmax > 1.6e-6)
          let badper = 1
        end
        let rms[sl] = rmin
        if rmin < gm[sl]
          let gm[sl] = rmin
        end
        if pmin < gpmin
          let gpmin = pmin
        end
        if pmax > gpmax
          let gpmax = pmax
        end
        let sl = sl + 1
      end

      let m0 = rms[0]*1e9
      let m1 = rms[1]*1e9
      let m2 = rms[2]*1e9
      let m3 = rms[3]*1e9
      let ecr = trise*1e9
      let ecf = tfall*1e9
      echo "RUN cseg=$cs voff=$vo psel=$ps mctr_ns=$&m0 mhigh_ns=$&m1 mlow_ns=$&m2 mvdd2_ns=$&m3 trise_ns=$&ecr tfall_ns=$&ecf"
      if (rms[0] < 0) | (badper = 1)
        echo "FAIL cseg=$cs voff=$vo psel=$ps: center-band margin $&m0 ns, period-window violation $&badper"
        quit 1
      end
    end
  end
end
let g0 = gm[0]*1e9
let g1 = gm[1]*1e9
let g2 = gm[2]*1e9
let g3 = gm[3]*1e9
let pn0 = gpmin*1e9
let pn1 = gpmax*1e9
echo "SUMMARY worst margins ns: center=$&g0 high=$&g1 low=$&g2 vdd2=$&g3 period_ns=$&pn0 to $&pn1"
echo "PASS all 24 runs x 4 slices (contract asserted at the center band)"
quit 0
.endc
.end
